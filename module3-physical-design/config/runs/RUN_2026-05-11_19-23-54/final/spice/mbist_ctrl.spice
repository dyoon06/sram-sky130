* NGSPICE file created from mbist_ctrl.ext - technology: sky130A

* Black-box entry subcircuit for sky130_fd_sc_hd__dfxtp_1 abstract view
.subckt sky130_fd_sc_hd__dfxtp_1 CLK D VGND VNB VPB VPWR Q
.ends

* Black-box entry subcircuit for sky130_fd_sc_hd__fill_1 abstract view
.subckt sky130_fd_sc_hd__fill_1 VGND VNB VPB VPWR
.ends

* Black-box entry subcircuit for sky130_fd_sc_hd__decap_3 abstract view
.subckt sky130_fd_sc_hd__decap_3 VGND VNB VPB VPWR
.ends

* Black-box entry subcircuit for sky130_fd_sc_hd__o211a_1 abstract view
.subckt sky130_fd_sc_hd__o211a_1 A1 A2 B1 C1 VGND VNB VPB VPWR X
.ends

* Black-box entry subcircuit for sky130_fd_sc_hd__and3_1 abstract view
.subckt sky130_fd_sc_hd__and3_1 A B C VGND VNB VPB VPWR X
.ends

* Black-box entry subcircuit for sky130_ef_sc_hd__decap_12 abstract view
.subckt sky130_ef_sc_hd__decap_12 VPWR VGND VPB VNB
.ends

* Black-box entry subcircuit for sky130_fd_sc_hd__fill_2 abstract view
.subckt sky130_fd_sc_hd__fill_2 VGND VNB VPB VPWR
.ends

* Black-box entry subcircuit for sky130_fd_sc_hd__buf_2 abstract view
.subckt sky130_fd_sc_hd__buf_2 A VGND VNB VPB VPWR X
.ends

* Black-box entry subcircuit for sky130_fd_sc_hd__decap_8 abstract view
.subckt sky130_fd_sc_hd__decap_8 VGND VNB VPB VPWR
.ends

* Black-box entry subcircuit for sky130_fd_sc_hd__or2_1 abstract view
.subckt sky130_fd_sc_hd__or2_1 A B VGND VNB VPB VPWR X
.ends

* Black-box entry subcircuit for sky130_fd_sc_hd__nand2_1 abstract view
.subckt sky130_fd_sc_hd__nand2_1 A B VGND VNB VPB VPWR Y
.ends

* Black-box entry subcircuit for sky130_fd_sc_hd__tapvpwrvgnd_1 abstract view
.subckt sky130_fd_sc_hd__tapvpwrvgnd_1 VGND VPWR
.ends

* Black-box entry subcircuit for sky130_fd_sc_hd__dlygate4sd3_1 abstract view
.subckt sky130_fd_sc_hd__dlygate4sd3_1 A VGND VNB VPB VPWR X
.ends

* Black-box entry subcircuit for sky130_fd_sc_hd__decap_6 abstract view
.subckt sky130_fd_sc_hd__decap_6 VGND VNB VPB VPWR
.ends

* Black-box entry subcircuit for sky130_fd_sc_hd__decap_4 abstract view
.subckt sky130_fd_sc_hd__decap_4 VGND VNB VPB VPWR
.ends

* Black-box entry subcircuit for sky130_fd_sc_hd__a21oi_1 abstract view
.subckt sky130_fd_sc_hd__a21oi_1 A1 A2 B1 VGND VNB VPB VPWR Y
.ends

* Black-box entry subcircuit for sky130_fd_sc_hd__o221a_1 abstract view
.subckt sky130_fd_sc_hd__o221a_1 A1 A2 B1 B2 C1 VGND VNB VPB VPWR X
.ends

* Black-box entry subcircuit for sky130_fd_sc_hd__a32o_1 abstract view
.subckt sky130_fd_sc_hd__a32o_1 A1 A2 A3 B1 B2 VGND VNB VPB VPWR X
.ends

* Black-box entry subcircuit for sky130_fd_sc_hd__a31o_1 abstract view
.subckt sky130_fd_sc_hd__a31o_1 A1 A2 A3 B1 VGND VNB VPB VPWR X
.ends

* Black-box entry subcircuit for sky130_fd_sc_hd__a311oi_1 abstract view
.subckt sky130_fd_sc_hd__a311oi_1 A1 A2 A3 B1 C1 VGND VNB VPB VPWR Y
.ends

* Black-box entry subcircuit for sky130_fd_sc_hd__dfxtp_2 abstract view
.subckt sky130_fd_sc_hd__dfxtp_2 CLK D VGND VNB VPB VPWR Q
.ends

* Black-box entry subcircuit for sky130_fd_sc_hd__a21o_1 abstract view
.subckt sky130_fd_sc_hd__a21o_1 A1 A2 B1 VGND VNB VPB VPWR X
.ends

* Black-box entry subcircuit for sky130_fd_sc_hd__nor2_1 abstract view
.subckt sky130_fd_sc_hd__nor2_1 A B VGND VNB VPB VPWR Y
.ends

* Black-box entry subcircuit for sky130_fd_sc_hd__clkbuf_8 abstract view
.subckt sky130_fd_sc_hd__clkbuf_8 A VGND VNB VPB VPWR X
.ends

* Black-box entry subcircuit for sky130_fd_sc_hd__xnor2_1 abstract view
.subckt sky130_fd_sc_hd__xnor2_1 A B VGND VNB VPB VPWR Y
.ends

* Black-box entry subcircuit for sky130_fd_sc_hd__clkbuf_4 abstract view
.subckt sky130_fd_sc_hd__clkbuf_4 A VGND VNB VPB VPWR X
.ends

* Black-box entry subcircuit for sky130_fd_sc_hd__and2b_1 abstract view
.subckt sky130_fd_sc_hd__and2b_1 A_N B VGND VNB VPB VPWR X
.ends

* Black-box entry subcircuit for sky130_fd_sc_hd__o21ai_1 abstract view
.subckt sky130_fd_sc_hd__o21ai_1 A1 A2 B1 VGND VNB VPB VPWR Y
.ends

* Black-box entry subcircuit for sky130_fd_sc_hd__a2bb2o_1 abstract view
.subckt sky130_fd_sc_hd__a2bb2o_1 A1_N A2_N B1 B2 VGND VNB VPB VPWR X
.ends

* Black-box entry subcircuit for sky130_fd_sc_hd__o31a_1 abstract view
.subckt sky130_fd_sc_hd__o31a_1 A1 A2 A3 B1 VGND VNB VPB VPWR X
.ends

* Black-box entry subcircuit for sky130_fd_sc_hd__a22o_1 abstract view
.subckt sky130_fd_sc_hd__a22o_1 A1 A2 B1 B2 VGND VNB VPB VPWR X
.ends

* Black-box entry subcircuit for sky130_fd_sc_hd__clkbuf_16 abstract view
.subckt sky130_fd_sc_hd__clkbuf_16 A VGND VNB VPB VPWR X
.ends

* Black-box entry subcircuit for sky130_fd_sc_hd__clkbuf_2 abstract view
.subckt sky130_fd_sc_hd__clkbuf_2 A VGND VNB VPB VPWR X
.ends

* Black-box entry subcircuit for sky130_fd_sc_hd__and2_1 abstract view
.subckt sky130_fd_sc_hd__and2_1 A B VGND VNB VPB VPWR X
.ends

* Black-box entry subcircuit for sky130_fd_sc_hd__or3_1 abstract view
.subckt sky130_fd_sc_hd__or3_1 A B C VGND VNB VPB VPWR X
.ends

* Black-box entry subcircuit for sky130_fd_sc_hd__inv_2 abstract view
.subckt sky130_fd_sc_hd__inv_2 A VGND VNB VPB VPWR Y
.ends

* Black-box entry subcircuit for sky130_fd_sc_hd__nor3_1 abstract view
.subckt sky130_fd_sc_hd__nor3_1 A B C VGND VNB VPB VPWR Y
.ends

* Black-box entry subcircuit for sky130_fd_sc_hd__nand2b_2 abstract view
.subckt sky130_fd_sc_hd__nand2b_2 A_N B VGND VNB VPB VPWR Y
.ends

* Black-box entry subcircuit for sky130_fd_sc_hd__buf_1 abstract view
.subckt sky130_fd_sc_hd__buf_1 A VGND VNB VPB VPWR X
.ends

* Black-box entry subcircuit for sky130_fd_sc_hd__or4_1 abstract view
.subckt sky130_fd_sc_hd__or4_1 A B C D VGND VNB VPB VPWR X
.ends

* Black-box entry subcircuit for sky130_fd_sc_hd__a21bo_1 abstract view
.subckt sky130_fd_sc_hd__a21bo_1 A1 A2 B1_N VGND VNB VPB VPWR X
.ends

* Black-box entry subcircuit for sky130_fd_sc_hd__and2_2 abstract view
.subckt sky130_fd_sc_hd__and2_2 A B VGND VNB VPB VPWR X
.ends

* Black-box entry subcircuit for sky130_fd_sc_hd__clkbuf_1 abstract view
.subckt sky130_fd_sc_hd__clkbuf_1 A VGND VNB VPB VPWR X
.ends

* Black-box entry subcircuit for sky130_fd_sc_hd__and4_1 abstract view
.subckt sky130_fd_sc_hd__and4_1 A B C D VGND VNB VPB VPWR X
.ends

* Black-box entry subcircuit for sky130_fd_sc_hd__o22a_1 abstract view
.subckt sky130_fd_sc_hd__o22a_1 A1 A2 B1 B2 VGND VNB VPB VPWR X
.ends

* Black-box entry subcircuit for sky130_fd_sc_hd__o311a_1 abstract view
.subckt sky130_fd_sc_hd__o311a_1 A1 A2 A3 B1 C1 VGND VNB VPB VPWR X
.ends

* Black-box entry subcircuit for sky130_fd_sc_hd__or4_2 abstract view
.subckt sky130_fd_sc_hd__or4_2 A B C D VGND VNB VPB VPWR X
.ends

* Black-box entry subcircuit for sky130_fd_sc_hd__a211o_1 abstract view
.subckt sky130_fd_sc_hd__a211o_1 A1 A2 B1 C1 VGND VNB VPB VPWR X
.ends

* Black-box entry subcircuit for sky130_fd_sc_hd__nand3_1 abstract view
.subckt sky130_fd_sc_hd__nand3_1 A B C VGND VNB VPB VPWR Y
.ends

* Black-box entry subcircuit for sky130_fd_sc_hd__mux2_1 abstract view
.subckt sky130_fd_sc_hd__mux2_1 A0 A1 S VGND VNB VPB VPWR X
.ends

* Black-box entry subcircuit for sky130_fd_sc_hd__and4_2 abstract view
.subckt sky130_fd_sc_hd__and4_2 A B C D VGND VNB VPB VPWR X
.ends

* Black-box entry subcircuit for sky130_fd_sc_hd__a21bo_2 abstract view
.subckt sky130_fd_sc_hd__a21bo_2 A1 A2 B1_N VGND VNB VPB VPWR X
.ends

* Black-box entry subcircuit for sky130_fd_sc_hd__o311a_2 abstract view
.subckt sky130_fd_sc_hd__o311a_2 A1 A2 A3 B1 C1 VGND VNB VPB VPWR X
.ends

* Black-box entry subcircuit for sky130_fd_sc_hd__nand2_2 abstract view
.subckt sky130_fd_sc_hd__nand2_2 A B VGND VNB VPB VPWR Y
.ends

* Black-box entry subcircuit for sky130_fd_sc_hd__nand2b_1 abstract view
.subckt sky130_fd_sc_hd__nand2b_1 A_N B VGND VNB VPB VPWR Y
.ends

* Black-box entry subcircuit for sky130_fd_sc_hd__o21ba_1 abstract view
.subckt sky130_fd_sc_hd__o21ba_1 A1 A2 B1_N VGND VNB VPB VPWR X
.ends

* Black-box entry subcircuit for sky130_fd_sc_hd__or2_2 abstract view
.subckt sky130_fd_sc_hd__or2_2 A B VGND VNB VPB VPWR X
.ends

* Black-box entry subcircuit for sky130_fd_sc_hd__or2_4 abstract view
.subckt sky130_fd_sc_hd__or2_4 A B VGND VNB VPB VPWR X
.ends

.subckt mbist_ctrl VGND VPWR clk diag_addr[0] diag_addr[1] diag_addr[2] diag_addr[3]
+ diag_addr[4] diag_addr[5] diag_addr[6] diag_addr[7] done mem_addr[0] mem_addr[1]
+ mem_addr[2] mem_addr[3] mem_addr[4] mem_addr[5] mem_addr[6] mem_addr[7] mem_ce mem_din[0]
+ mem_din[1] mem_din[2] mem_din[3] mem_din[4] mem_din[5] mem_din[6] mem_din[7] mem_dout[0]
+ mem_dout[1] mem_dout[2] mem_dout[3] mem_dout[4] mem_dout[5] mem_dout[6] mem_dout[7]
+ mem_we pass_fail rst start
X_294_ clknet_2_2__leaf_clk _002_ VGND VGND VPWR VPWR phase\[2\] sky130_fd_sc_hd__dfxtp_1
XFILLER_13_111 VGND VGND VPWR VPWR sky130_fd_sc_hd__fill_1
XPHY_EDGE_ROW_0_Left_23 VGND VGND VPWR VPWR sky130_fd_sc_hd__decap_3
XFILLER_10_114 VGND VGND VPWR VPWR sky130_fd_sc_hd__fill_1
X_277_ net1 _145_ _129_ net41 VGND VGND VPWR VPWR _032_ sky130_fd_sc_hd__o211a_1
X_200_ read_data\[1\] read_data\[0\] phase\[1\] VGND VGND VPWR VPWR _075_ sky130_fd_sc_hd__and3_1
XFILLER_0_57 VPWR VGND VPWR VGND sky130_ef_sc_hd__decap_12
X_329_ clknet_2_0__leaf_clk _037_ VGND VGND VPWR VPWR read_data\[5\] sky130_fd_sc_hd__dfxtp_1
XFILLER_18_97 VGND VGND VPWR VPWR sky130_fd_sc_hd__decap_3
XFILLER_13_3 VGND VGND VPWR VPWR sky130_fd_sc_hd__fill_1
XFILLER_15_98 VGND VGND VPWR VPWR sky130_fd_sc_hd__fill_2
Xoutput20 net20 VGND VGND VPWR VPWR mem_addr[0] sky130_fd_sc_hd__buf_2
Xoutput31 net31 VGND VGND VPWR VPWR mem_din[2] sky130_fd_sc_hd__buf_2
X_293_ clknet_2_2__leaf_clk _001_ VGND VGND VPWR VPWR phase\[1\] sky130_fd_sc_hd__dfxtp_1
XFILLER_12_55 VGND VGND VPWR VPWR sky130_fd_sc_hd__decap_8
X_276_ read_data\[0\] _144_ VGND VGND VPWR VPWR _129_ sky130_fd_sc_hd__or2_1
XPHY_EDGE_ROW_21_Right_21 VGND VGND VPWR VPWR sky130_fd_sc_hd__decap_3
XPHY_EDGE_ROW_12_Right_12 VGND VGND VPWR VPWR sky130_fd_sc_hd__decap_3
X_328_ clknet_2_0__leaf_clk _036_ VGND VGND VPWR VPWR read_data\[4\] sky130_fd_sc_hd__dfxtp_1
XFILLER_0_69 VPWR VGND VPWR VGND sky130_ef_sc_hd__decap_12
X_259_ _142_ _117_ VGND VGND VPWR VPWR _118_ sky130_fd_sc_hd__nand2_1
XFILLER_15_7 VGND VGND VPWR VPWR sky130_fd_sc_hd__decap_3
XTAP_TAPCELL_ROW_20_88 VGND VPWR sky130_fd_sc_hd__tapvpwrvgnd_1
Xhold20 read_data\[4\] VGND VGND VPWR VPWR net66 sky130_fd_sc_hd__dlygate4sd3_1
XFILLER_15_66 VPWR VGND VPWR VGND sky130_ef_sc_hd__decap_12
XPHY_EDGE_ROW_6_Right_6 VGND VGND VPWR VPWR sky130_fd_sc_hd__decap_3
Xoutput21 net21 VGND VGND VPWR VPWR mem_addr[1] sky130_fd_sc_hd__buf_2
XFILLER_16_121 VGND VGND VPWR VPWR sky130_fd_sc_hd__decap_8
Xoutput32 net32 VGND VGND VPWR VPWR mem_din[3] sky130_fd_sc_hd__buf_2
XFILLER_22_113 VGND VGND VPWR VPWR sky130_fd_sc_hd__fill_2
X_292_ clknet_2_3__leaf_clk net61 VGND VGND VPWR VPWR phase\[0\] sky130_fd_sc_hd__dfxtp_1
XFILLER_13_113 VGND VGND VPWR VPWR sky130_fd_sc_hd__decap_6
XFILLER_12_23 VGND VGND VPWR VPWR sky130_fd_sc_hd__decap_4
X_275_ _077_ _128_ net45 VGND VGND VPWR VPWR _031_ sky130_fd_sc_hd__a21oi_1
XFILLER_3_3 VGND VGND VPWR VPWR sky130_fd_sc_hd__decap_4
XFILLER_0_48 VGND VGND VPWR VPWR sky130_fd_sc_hd__decap_4
XFILLER_0_15 VGND VGND VPWR VPWR sky130_fd_sc_hd__fill_1
X_327_ clknet_2_0__leaf_clk _035_ VGND VGND VPWR VPWR read_data\[3\] sky130_fd_sc_hd__dfxtp_1
X_258_ phase\[2\] _050_ net39 _052_ _049_ VGND VGND VPWR VPWR _117_ sky130_fd_sc_hd__o221a_1
X_189_ state\[2\] _047_ _055_ _057_ net62 VGND VGND VPWR VPWR _009_ sky130_fd_sc_hd__a32o_1
XFILLER_9_57 VGND VGND VPWR VPWR sky130_fd_sc_hd__fill_2
XTAP_TAPCELL_ROW_5_58 VGND VPWR sky130_fd_sc_hd__tapvpwrvgnd_1
XTAP_TAPCELL_ROW_20_89 VGND VPWR sky130_fd_sc_hd__tapvpwrvgnd_1
XPHY_EDGE_ROW_16_Left_39 VGND VGND VPWR VPWR sky130_fd_sc_hd__decap_3
Xhold21 read_data\[3\] VGND VGND VPWR VPWR net67 sky130_fd_sc_hd__dlygate4sd3_1
XFILLER_6_25 VGND VGND VPWR VPWR sky130_fd_sc_hd__decap_3
Xhold10 _029_ VGND VGND VPWR VPWR net56 sky130_fd_sc_hd__dlygate4sd3_1
XTAP_TAPCELL_ROW_15_78 VGND VPWR sky130_fd_sc_hd__tapvpwrvgnd_1
Xoutput22 net22 VGND VGND VPWR VPWR mem_addr[2] sky130_fd_sc_hd__buf_2
XFILLER_16_111 VGND VGND VPWR VPWR sky130_fd_sc_hd__decap_3
XFILLER_15_78 VPWR VGND VPWR VGND sky130_ef_sc_hd__decap_12
Xoutput33 net33 VGND VGND VPWR VPWR mem_din[4] sky130_fd_sc_hd__buf_2
Xoutput11 net11 VGND VGND VPWR VPWR diag_addr[0] sky130_fd_sc_hd__buf_2
X_291_ net8 _145_ _136_ net41 VGND VGND VPWR VPWR _039_ sky130_fd_sc_hd__o211a_1
XFILLER_13_103 VGND VGND VPWR VPWR sky130_fd_sc_hd__decap_8
XPHY_EDGE_ROW_19_Left_42 VGND VGND VPWR VPWR sky130_fd_sc_hd__decap_3
XFILLER_12_35 VPWR VGND VPWR VGND sky130_ef_sc_hd__decap_12
X_274_ _072_ _076_ _126_ _137_ VGND VGND VPWR VPWR _128_ sky130_fd_sc_hd__a31o_1
XFILLER_0_27 VGND VGND VPWR VPWR sky130_fd_sc_hd__fill_1
XPHY_EDGE_ROW_4_Left_27 VGND VGND VPWR VPWR sky130_fd_sc_hd__decap_3
X_326_ clknet_2_0__leaf_clk _034_ VGND VGND VPWR VPWR read_data\[2\] sky130_fd_sc_hd__dfxtp_1
X_188_ state\[1\] _055_ _062_ _064_ state\[5\] VGND VGND VPWR VPWR _008_ sky130_fd_sc_hd__a32o_1
XFILLER_9_36 VGND VGND VPWR VPWR sky130_fd_sc_hd__fill_2
X_257_ _090_ _113_ _115_ _116_ net46 VGND VGND VPWR VPWR _025_ sky130_fd_sc_hd__a311oi_1
XTAP_TAPCELL_ROW_5_59 VGND VPWR sky130_fd_sc_hd__tapvpwrvgnd_1
X_309_ clknet_2_2__leaf_clk _009_ VGND VGND VPWR VPWR state\[6\] sky130_fd_sc_hd__dfxtp_2
XFILLER_1_81 VGND VGND VPWR VPWR sky130_fd_sc_hd__decap_4
Xhold22 read_data\[1\] VGND VGND VPWR VPWR net68 sky130_fd_sc_hd__dlygate4sd3_1
XPHY_EDGE_ROW_7_Left_30 VGND VGND VPWR VPWR sky130_fd_sc_hd__decap_3
XFILLER_6_37 VGND VGND VPWR VPWR sky130_fd_sc_hd__decap_3
XFILLER_6_48 VGND VGND VPWR VPWR sky130_fd_sc_hd__decap_6
Xhold11 net28 VGND VGND VPWR VPWR net57 sky130_fd_sc_hd__dlygate4sd3_1
XTAP_TAPCELL_ROW_15_79 VGND VPWR sky130_fd_sc_hd__tapvpwrvgnd_1
Xoutput23 net23 VGND VGND VPWR VPWR mem_addr[3] sky130_fd_sc_hd__buf_2
Xoutput12 net12 VGND VGND VPWR VPWR diag_addr[1] sky130_fd_sc_hd__buf_2
Xoutput34 net34 VGND VGND VPWR VPWR mem_din[5] sky130_fd_sc_hd__buf_2
XFILLER_11_3 VGND VGND VPWR VPWR sky130_fd_sc_hd__fill_1
XFILLER_22_126 VGND VGND VPWR VPWR sky130_fd_sc_hd__decap_6
X_290_ read_data\[7\] _144_ VGND VGND VPWR VPWR _136_ sky130_fd_sc_hd__or2_1
X_273_ _077_ _127_ net45 VGND VGND VPWR VPWR _030_ sky130_fd_sc_hd__a21o_1
XPHY_EDGE_ROW_20_Left_43 VGND VGND VPWR VPWR sky130_fd_sc_hd__decap_3
X_325_ clknet_2_0__leaf_clk _033_ VGND VGND VPWR VPWR read_data\[1\] sky130_fd_sc_hd__dfxtp_1
X_187_ net69 _064_ _065_ VGND VGND VPWR VPWR _004_ sky130_fd_sc_hd__a21o_1
X_256_ net27 _090_ VGND VGND VPWR VPWR _116_ sky130_fd_sc_hd__nor2_1
Xclkload0 clknet_2_0__leaf_clk VGND VGND VPWR VPWR clkload0/X sky130_fd_sc_hd__clkbuf_8
X_239_ net40 _059_ VGND VGND VPWR VPWR _102_ sky130_fd_sc_hd__xnor2_1
X_308_ clknet_2_2__leaf_clk _008_ VGND VGND VPWR VPWR state\[5\] sky130_fd_sc_hd__dfxtp_1
Xhold23 state\[1\] VGND VGND VPWR VPWR net69 sky130_fd_sc_hd__dlygate4sd3_1
Xhold12 _028_ VGND VGND VPWR VPWR net58 sky130_fd_sc_hd__dlygate4sd3_1
XFILLER_19_132 VGND VGND VPWR VPWR sky130_fd_sc_hd__fill_1
Xoutput24 net24 VGND VGND VPWR VPWR mem_addr[4] sky130_fd_sc_hd__buf_2
Xoutput13 net13 VGND VGND VPWR VPWR diag_addr[2] sky130_fd_sc_hd__buf_2
Xoutput35 net35 VGND VGND VPWR VPWR mem_din[6] sky130_fd_sc_hd__buf_2
XTAP_TAPCELL_ROW_21_90 VGND VPWR sky130_fd_sc_hd__tapvpwrvgnd_1
XPHY_EDGE_ROW_19_Right_19 VGND VGND VPWR VPWR sky130_fd_sc_hd__decap_3
XFILLER_16_102 VGND VGND VPWR VPWR sky130_fd_sc_hd__fill_2
X_272_ _072_ _076_ _126_ net65 VGND VGND VPWR VPWR _127_ sky130_fd_sc_hd__a31o_1
XFILLER_4_82 VGND VGND VPWR VPWR sky130_fd_sc_hd__fill_2
X_324_ clknet_2_2__leaf_clk _032_ VGND VGND VPWR VPWR read_data\[0\] sky130_fd_sc_hd__dfxtp_1
XFILLER_0_29 VPWR VGND VPWR VGND sky130_ef_sc_hd__decap_12
X_186_ state\[6\] _047_ _055_ VGND VGND VPWR VPWR _065_ sky130_fd_sc_hd__and3_1
X_255_ _138_ _047_ _114_ VGND VGND VPWR VPWR _115_ sky130_fd_sc_hd__a21o_1
XFILLER_18_69 VGND VGND VPWR VPWR sky130_fd_sc_hd__decap_3
Xclkload1 clknet_2_1__leaf_clk VGND VGND VPWR VPWR clkload1/X sky130_fd_sc_hd__clkbuf_4
XFILLER_1_3 VGND VGND VPWR VPWR sky130_fd_sc_hd__fill_2
X_238_ net23 _090_ _091_ _101_ net43 VGND VGND VPWR VPWR _021_ sky130_fd_sc_hd__o221a_1
X_169_ _048_ _053_ VGND VGND VPWR VPWR _054_ sky130_fd_sc_hd__nand2_1
X_307_ clknet_2_3__leaf_clk _007_ VGND VGND VPWR VPWR state\[4\] sky130_fd_sc_hd__dfxtp_1
Xhold13 net37 VGND VGND VPWR VPWR net59 sky130_fd_sc_hd__dlygate4sd3_1
Xhold24 diag_captured VGND VGND VPWR VPWR net70 sky130_fd_sc_hd__dlygate4sd3_1
XTAP_TAPCELL_ROW_6_60 VGND VPWR sky130_fd_sc_hd__tapvpwrvgnd_1
Xoutput25 net25 VGND VGND VPWR VPWR mem_addr[5] sky130_fd_sc_hd__buf_2
Xoutput14 net14 VGND VGND VPWR VPWR diag_addr[3] sky130_fd_sc_hd__buf_2
XTAP_TAPCELL_ROW_21_91 VGND VPWR sky130_fd_sc_hd__tapvpwrvgnd_1
Xoutput36 net36 VGND VGND VPWR VPWR mem_din[7] sky130_fd_sc_hd__buf_2
XTAP_TAPCELL_ROW_16_80 VGND VPWR sky130_fd_sc_hd__tapvpwrvgnd_1
XFILLER_13_128 VGND VGND VPWR VPWR sky130_fd_sc_hd__fill_1
XFILLER_12_27 VGND VGND VPWR VPWR sky130_fd_sc_hd__fill_1
X_271_ _066_ _089_ VGND VGND VPWR VPWR _126_ sky130_fd_sc_hd__and2b_1
XFILLER_4_50 VPWR VGND VPWR VGND sky130_ef_sc_hd__decap_12
XFILLER_3_7 VGND VGND VPWR VPWR sky130_fd_sc_hd__fill_1
X_185_ phase\[1\] _062_ net45 VGND VGND VPWR VPWR _064_ sky130_fd_sc_hd__a21oi_1
X_323_ clknet_2_1__leaf_clk _031_ VGND VGND VPWR VPWR diag_captured sky130_fd_sc_hd__dfxtp_1
X_254_ net27 _045_ _051_ VGND VGND VPWR VPWR _114_ sky130_fd_sc_hd__o21ai_1
XFILLER_13_92 VGND VGND VPWR VPWR sky130_fd_sc_hd__fill_2
Xclkload2 clknet_2_3__leaf_clk VGND VGND VPWR VPWR clkload2/X sky130_fd_sc_hd__clkbuf_4
X_237_ _042_ _100_ _099_ _141_ VGND VGND VPWR VPWR _101_ sky130_fd_sc_hd__a2bb2o_1
X_306_ clknet_2_2__leaf_clk _006_ VGND VGND VPWR VPWR state\[3\] sky130_fd_sc_hd__dfxtp_1
X_168_ state\[0\] _141_ net39 _049_ VGND VGND VPWR VPWR _053_ sky130_fd_sc_hd__o31a_1
Xhold25 read_data\[2\] VGND VGND VPWR VPWR net71 sky130_fd_sc_hd__dlygate4sd3_1
Xhold14 state\[4\] VGND VGND VPWR VPWR net60 sky130_fd_sc_hd__dlygate4sd3_1
XFILLER_10_71 VGND VGND VPWR VPWR sky130_fd_sc_hd__decap_4
XFILLER_10_82 VGND VGND VPWR VPWR sky130_fd_sc_hd__fill_2
XTAP_TAPCELL_ROW_6_61 VGND VPWR sky130_fd_sc_hd__tapvpwrvgnd_1
XFILLER_15_38 VGND VGND VPWR VPWR sky130_fd_sc_hd__decap_6
Xoutput15 net15 VGND VGND VPWR VPWR diag_addr[4] sky130_fd_sc_hd__buf_2
Xoutput26 net26 VGND VGND VPWR VPWR mem_addr[6] sky130_fd_sc_hd__buf_2
XPHY_EDGE_ROW_1_Right_1 VGND VGND VPWR VPWR sky130_fd_sc_hd__decap_3
Xoutput37 net37 VGND VGND VPWR VPWR mem_we sky130_fd_sc_hd__buf_2
XTAP_TAPCELL_ROW_16_81 VGND VPWR sky130_fd_sc_hd__tapvpwrvgnd_1
X_270_ state\[3\] net42 _125_ net55 VGND VGND VPWR VPWR _029_ sky130_fd_sc_hd__a22o_1
XFILLER_4_62 VGND VGND VPWR VPWR sky130_fd_sc_hd__fill_1
XFILLER_9_18 VGND VGND VPWR VPWR sky130_fd_sc_hd__fill_1
X_322_ clknet_2_0__leaf_clk _030_ VGND VGND VPWR VPWR net38 sky130_fd_sc_hd__dfxtp_1
X_184_ net46 _048_ _063_ net10 VGND VGND VPWR VPWR _007_ sky130_fd_sc_hd__a2bb2o_1
X_253_ _062_ _112_ _141_ VGND VGND VPWR VPWR _113_ sky130_fd_sc_hd__o21ai_1
X_236_ net23 _041_ net39 VGND VGND VPWR VPWR _100_ sky130_fd_sc_hd__o21ai_1
X_167_ state\[0\] state\[1\] VGND VGND VPWR VPWR _052_ sky130_fd_sc_hd__or2_1
X_305_ clknet_2_2__leaf_clk _005_ VGND VGND VPWR VPWR state\[2\] sky130_fd_sc_hd__dfxtp_1
XFILLER_1_85 VGND VGND VPWR VPWR sky130_fd_sc_hd__fill_1
Xhold26 read_data\[5\] VGND VGND VPWR VPWR net72 sky130_fd_sc_hd__dlygate4sd3_1
XFILLER_10_94 VGND VGND VPWR VPWR sky130_fd_sc_hd__decap_4
Xhold15 _000_ VGND VGND VPWR VPWR net61 sky130_fd_sc_hd__dlygate4sd3_1
XPHY_EDGE_ROW_11_Left_34 VGND VGND VPWR VPWR sky130_fd_sc_hd__decap_3
X_219_ net27 _078_ net45 VGND VGND VPWR VPWR _087_ sky130_fd_sc_hd__a21o_1
Xoutput16 net16 VGND VGND VPWR VPWR diag_addr[5] sky130_fd_sc_hd__buf_2
Xoutput38 net38 VGND VGND VPWR VPWR pass_fail sky130_fd_sc_hd__buf_2
Xoutput27 net27 VGND VGND VPWR VPWR mem_addr[7] sky130_fd_sc_hd__buf_2
XFILLER_22_119 VGND VGND VPWR VPWR sky130_fd_sc_hd__decap_3
XFILLER_21_82 VPWR VGND VPWR VGND sky130_ef_sc_hd__decap_12
Xclkbuf_0_clk clk VGND VGND VPWR VPWR clknet_0_clk sky130_fd_sc_hd__clkbuf_16
XPHY_EDGE_ROW_15_Right_15 VGND VGND VPWR VPWR sky130_fd_sc_hd__decap_3
XFILLER_13_119 VGND VGND VPWR VPWR sky130_fd_sc_hd__fill_1
XFILLER_4_85 VGND VGND VPWR VPWR sky130_fd_sc_hd__fill_2
Xfanout40 net24 VGND VGND VPWR VPWR net40 sky130_fd_sc_hd__clkbuf_2
X_321_ clknet_2_2__leaf_clk net56 VGND VGND VPWR VPWR net19 sky130_fd_sc_hd__dfxtp_1
X_183_ net43 state\[0\] VGND VGND VPWR VPWR _063_ sky130_fd_sc_hd__and2_1
X_252_ net27 _061_ VGND VGND VPWR VPWR _112_ sky130_fd_sc_hd__and2_1
X_235_ _059_ _098_ VGND VGND VPWR VPWR _099_ sky130_fd_sc_hd__nand2_1
X_304_ clknet_2_2__leaf_clk _004_ VGND VGND VPWR VPWR state\[1\] sky130_fd_sc_hd__dfxtp_1
XFILLER_1_53 VGND VGND VPWR VPWR sky130_fd_sc_hd__decap_3
XFILLER_1_42 VGND VGND VPWR VPWR sky130_fd_sc_hd__decap_3
X_166_ state\[6\] state\[4\] state\[2\] VGND VGND VPWR VPWR _051_ sky130_fd_sc_hd__or3_1
Xhold16 state\[6\] VGND VGND VPWR VPWR net62 sky130_fd_sc_hd__dlygate4sd3_1
X_149_ net45 VGND VGND VPWR VPWR _140_ sky130_fd_sc_hd__inv_2
X_218_ net52 _079_ _086_ VGND VGND VPWR VPWR _016_ sky130_fd_sc_hd__a21o_1
Xoutput28 net28 VGND VGND VPWR VPWR mem_ce sky130_fd_sc_hd__buf_2
Xoutput17 net17 VGND VGND VPWR VPWR diag_addr[6] sky130_fd_sc_hd__buf_2
XFILLER_21_94 VGND VGND VPWR VPWR sky130_fd_sc_hd__decap_4
XFILLER_7_96 VGND VGND VPWR VPWR sky130_fd_sc_hd__fill_2
XFILLER_21_131 VGND VGND VPWR VPWR sky130_fd_sc_hd__fill_2
XFILLER_16_94 VGND VGND VPWR VPWR sky130_fd_sc_hd__decap_8
XFILLER_16_50 VPWR VGND VPWR VGND sky130_ef_sc_hd__decap_12
XFILLER_12_131 VGND VGND VPWR VPWR sky130_fd_sc_hd__fill_2
Xclkbuf_2_0__f_clk clknet_0_clk VGND VGND VPWR VPWR clknet_2_0__leaf_clk sky130_fd_sc_hd__clkbuf_16
X_251_ net26 _090_ _091_ _111_ net43 VGND VGND VPWR VPWR _024_ sky130_fd_sc_hd__o221a_1
Xfanout41 net44 VGND VGND VPWR VPWR net41 sky130_fd_sc_hd__buf_2
X_182_ state\[5\] _055_ _062_ net42 net63 VGND VGND VPWR VPWR _006_ sky130_fd_sc_hd__a32o_1
X_320_ clknet_2_3__leaf_clk net58 VGND VGND VPWR VPWR net28 sky130_fd_sc_hd__dfxtp_1
XFILLER_18_29 VGND VGND VPWR VPWR sky130_fd_sc_hd__decap_4
X_234_ net22 _058_ net23 VGND VGND VPWR VPWR _098_ sky130_fd_sc_hd__o21ai_1
X_303_ clknet_2_2__leaf_clk _003_ VGND VGND VPWR VPWR state\[0\] sky130_fd_sc_hd__dfxtp_1
X_165_ state\[6\] state\[2\] state\[1\] VGND VGND VPWR VPWR _050_ sky130_fd_sc_hd__nor3_1
Xhold17 state\[3\] VGND VGND VPWR VPWR net63 sky130_fd_sc_hd__dlygate4sd3_1
X_148_ state\[5\] VGND VGND VPWR VPWR _139_ sky130_fd_sc_hd__inv_2
XFILLER_10_85 VGND VGND VPWR VPWR sky130_fd_sc_hd__fill_1
X_217_ net26 _078_ net46 VGND VGND VPWR VPWR _086_ sky130_fd_sc_hd__a21o_1
Xoutput29 net29 VGND VGND VPWR VPWR mem_din[0] sky130_fd_sc_hd__buf_2
Xoutput18 net18 VGND VGND VPWR VPWR diag_addr[7] sky130_fd_sc_hd__buf_2
XPHY_EDGE_ROW_5_Right_5 VGND VGND VPWR VPWR sky130_fd_sc_hd__decap_3
XFILLER_16_62 VPWR VGND VPWR VGND sky130_ef_sc_hd__decap_12
XTAP_TAPCELL_ROW_3_54 VGND VPWR sky130_fd_sc_hd__tapvpwrvgnd_1
Xfanout42 net44 VGND VGND VPWR VPWR net42 sky130_fd_sc_hd__buf_2
XTAP_TAPCELL_ROW_13_74 VGND VPWR sky130_fd_sc_hd__tapvpwrvgnd_1
X_181_ net27 _061_ VGND VGND VPWR VPWR _062_ sky130_fd_sc_hd__nor2_1
X_250_ _046_ net39 _110_ _109_ _141_ VGND VGND VPWR VPWR _111_ sky130_fd_sc_hd__a32o_1
X_233_ net22 _090_ _091_ _097_ net44 VGND VGND VPWR VPWR _020_ sky130_fd_sc_hd__o221a_1
X_164_ net10 state\[0\] VGND VGND VPWR VPWR _049_ sky130_fd_sc_hd__nand2b_2
X_302_ clknet_2_0__leaf_clk _017_ VGND VGND VPWR VPWR net18 sky130_fd_sc_hd__dfxtp_1
Xhold18 state\[2\] VGND VGND VPWR VPWR net64 sky130_fd_sc_hd__dlygate4sd3_1
XFILLER_19_95 VGND VGND VPWR VPWR sky130_fd_sc_hd__decap_4
XFILLER_10_75 VGND VGND VPWR VPWR sky130_fd_sc_hd__fill_1
XFILLER_18_3 VGND VGND VPWR VPWR sky130_fd_sc_hd__fill_1
X_216_ net48 _079_ _085_ VGND VGND VPWR VPWR _015_ sky130_fd_sc_hd__a21o_1
X_147_ state\[6\] VGND VGND VPWR VPWR _138_ sky130_fd_sc_hd__inv_2
Xoutput19 net19 VGND VGND VPWR VPWR done sky130_fd_sc_hd__buf_2
XPHY_EDGE_ROW_15_Left_38 VGND VGND VPWR VPWR sky130_fd_sc_hd__decap_3
XPHY_EDGE_ROW_20_Right_20 VGND VGND VPWR VPWR sky130_fd_sc_hd__decap_3
XFILLER_16_85 VGND VGND VPWR VPWR sky130_fd_sc_hd__fill_2
XFILLER_16_74 VGND VGND VPWR VPWR sky130_fd_sc_hd__decap_4
XTAP_TAPCELL_ROW_3_55 VGND VPWR sky130_fd_sc_hd__tapvpwrvgnd_1
XPHY_EDGE_ROW_11_Right_11 VGND VGND VPWR VPWR sky130_fd_sc_hd__decap_3
Xfanout43 net44 VGND VGND VPWR VPWR net43 sky130_fd_sc_hd__buf_1
XPHY_EDGE_ROW_18_Left_41 VGND VGND VPWR VPWR sky130_fd_sc_hd__decap_3
X_180_ net26 net25 net40 _059_ VGND VGND VPWR VPWR _061_ sky130_fd_sc_hd__or4_1
XFILLER_13_20 VPWR VGND VPWR VGND sky130_ef_sc_hd__decap_12
XTAP_TAPCELL_ROW_13_75 VGND VPWR sky130_fd_sc_hd__tapvpwrvgnd_1
XFILLER_1_110 VGND VGND VPWR VPWR sky130_fd_sc_hd__fill_2
XPHY_EDGE_ROW_3_Left_26 VGND VGND VPWR VPWR sky130_fd_sc_hd__decap_3
X_232_ _141_ _094_ _096_ net39 VGND VGND VPWR VPWR _097_ sky130_fd_sc_hd__a22o_1
X_163_ net27 _045_ state\[4\] VGND VGND VPWR VPWR _048_ sky130_fd_sc_hd__a21bo_1
X_301_ clknet_2_1__leaf_clk _016_ VGND VGND VPWR VPWR net17 sky130_fd_sc_hd__dfxtp_1
Xhold19 net38 VGND VGND VPWR VPWR net65 sky130_fd_sc_hd__dlygate4sd3_1
XFILLER_10_98 VGND VGND VPWR VPWR sky130_fd_sc_hd__fill_1
X_215_ net25 _078_ net46 VGND VGND VPWR VPWR _085_ sky130_fd_sc_hd__a21o_1
X_146_ net70 VGND VGND VPWR VPWR _137_ sky130_fd_sc_hd__inv_2
XFILLER_21_20 VGND VGND VPWR VPWR sky130_fd_sc_hd__fill_1
XFILLER_15_131 VGND VGND VPWR VPWR sky130_fd_sc_hd__fill_2
XFILLER_7_55 VGND VGND VPWR VPWR sky130_fd_sc_hd__fill_1
XFILLER_7_88 VGND VGND VPWR VPWR sky130_fd_sc_hd__decap_8
Xfanout44 _140_ VGND VGND VPWR VPWR net44 sky130_fd_sc_hd__buf_1
XTAP_TAPCELL_ROW_0_46 VGND VPWR sky130_fd_sc_hd__tapvpwrvgnd_1
XFILLER_8_3 VGND VGND VPWR VPWR sky130_fd_sc_hd__decap_6
XTAP_TAPCELL_ROW_9_66 VGND VPWR sky130_fd_sc_hd__tapvpwrvgnd_1
XFILLER_13_32 VPWR VGND VPWR VGND sky130_ef_sc_hd__decap_12
X_231_ _041_ _095_ VGND VGND VPWR VPWR _096_ sky130_fd_sc_hd__nor2_1
X_300_ clknet_2_1__leaf_clk _015_ VGND VGND VPWR VPWR net16 sky130_fd_sc_hd__dfxtp_1
X_162_ net27 _045_ VGND VGND VPWR VPWR _047_ sky130_fd_sc_hd__and2_2
XFILLER_1_57 VPWR VGND VPWR VGND sky130_ef_sc_hd__decap_12
XTAP_TAPCELL_ROW_19_86 VGND VPWR sky130_fd_sc_hd__tapvpwrvgnd_1
Xinput1 mem_dout[0] VGND VGND VPWR VPWR net1 sky130_fd_sc_hd__clkbuf_1
XFILLER_10_11 VPWR VGND VPWR VGND sky130_ef_sc_hd__decap_12
X_214_ net54 _079_ _084_ VGND VGND VPWR VPWR _014_ sky130_fd_sc_hd__a21o_1
XFILLER_21_98 VGND VGND VPWR VPWR sky130_fd_sc_hd__fill_1
XFILLER_21_113 VGND VGND VPWR VPWR sky130_fd_sc_hd__fill_2
XPHY_EDGE_ROW_9_Right_9 VGND VGND VPWR VPWR sky130_fd_sc_hd__decap_3
XTAP_TAPCELL_ROW_0_47 VGND VPWR sky130_fd_sc_hd__tapvpwrvgnd_1
Xfanout45 net46 VGND VGND VPWR VPWR net45 sky130_fd_sc_hd__buf_2
XTAP_TAPCELL_ROW_9_67 VGND VPWR sky130_fd_sc_hd__tapvpwrvgnd_1
XFILLER_13_44 VPWR VGND VPWR VGND sky130_ef_sc_hd__decap_12
X_230_ net21 net20 net22 VGND VGND VPWR VPWR _095_ sky130_fd_sc_hd__a21oi_1
X_161_ _045_ VGND VGND VPWR VPWR _046_ sky130_fd_sc_hd__inv_2
XFILLER_1_69 VPWR VGND VPWR VGND sky130_ef_sc_hd__decap_12
XTAP_TAPCELL_ROW_19_87 VGND VPWR sky130_fd_sc_hd__tapvpwrvgnd_1
Xinput2 mem_dout[1] VGND VGND VPWR VPWR net2 sky130_fd_sc_hd__clkbuf_1
XFILLER_10_23 VGND VGND VPWR VPWR sky130_fd_sc_hd__decap_4
XFILLER_10_45 VGND VGND VPWR VPWR sky130_fd_sc_hd__fill_2
X_213_ net24 _078_ net46 VGND VGND VPWR VPWR _084_ sky130_fd_sc_hd__a21o_1
XFILLER_21_55 VGND VGND VPWR VPWR sky130_fd_sc_hd__fill_1
XFILLER_7_35 VGND VGND VPWR VPWR sky130_fd_sc_hd__fill_2
XFILLER_1_113 VGND VGND VPWR VPWR sky130_fd_sc_hd__decap_3
XTAP_TAPCELL_ROW_0_48 VGND VPWR sky130_fd_sc_hd__tapvpwrvgnd_1
XFILLER_1_102 VGND VGND VPWR VPWR sky130_fd_sc_hd__decap_8
Xfanout46 net9 VGND VGND VPWR VPWR net46 sky130_fd_sc_hd__clkbuf_2
X_160_ net26 net25 net40 _042_ VGND VGND VPWR VPWR _045_ sky130_fd_sc_hd__and4_1
XPHY_EDGE_ROW_18_Right_18 VGND VGND VPWR VPWR sky130_fd_sc_hd__decap_3
Xinput3 mem_dout[2] VGND VGND VPWR VPWR net3 sky130_fd_sc_hd__clkbuf_1
X_289_ net7 _145_ _135_ net41 VGND VGND VPWR VPWR _038_ sky130_fd_sc_hd__o211a_1
XTAP_TAPCELL_ROW_10_68 VGND VPWR sky130_fd_sc_hd__tapvpwrvgnd_1
X_212_ net50 _079_ _083_ VGND VGND VPWR VPWR _013_ sky130_fd_sc_hd__a21o_1
XFILLER_21_67 VGND VGND VPWR VPWR sky130_fd_sc_hd__decap_4
XPHY_EDGE_ROW_0_Right_0 VGND VGND VPWR VPWR sky130_fd_sc_hd__decap_3
XFILLER_4_111 VGND VGND VPWR VPWR sky130_fd_sc_hd__decap_8
XTAP_TAPCELL_ROW_0_49 VGND VPWR sky130_fd_sc_hd__tapvpwrvgnd_1
Xclkbuf_2_1__f_clk clknet_0_clk VGND VGND VPWR VPWR clknet_2_1__leaf_clk sky130_fd_sc_hd__clkbuf_16
Xinput4 mem_dout[3] VGND VGND VPWR VPWR net4 sky130_fd_sc_hd__clkbuf_1
X_288_ read_data\[6\] _144_ VGND VGND VPWR VPWR _135_ sky130_fd_sc_hd__or2_1
XTAP_TAPCELL_ROW_10_69 VGND VPWR sky130_fd_sc_hd__tapvpwrvgnd_1
X_211_ net23 _078_ net45 VGND VGND VPWR VPWR _083_ sky130_fd_sc_hd__a21o_1
XFILLER_21_57 VGND VGND VPWR VPWR sky130_fd_sc_hd__decap_3
XFILLER_21_35 VGND VGND VPWR VPWR sky130_fd_sc_hd__decap_4
XFILLER_2_81 VGND VGND VPWR VPWR sky130_fd_sc_hd__decap_3
XFILLER_15_113 VGND VGND VPWR VPWR sky130_fd_sc_hd__fill_2
XPHY_EDGE_ROW_10_Left_33 VGND VGND VPWR VPWR sky130_fd_sc_hd__decap_3
XFILLER_21_3 VGND VGND VPWR VPWR sky130_fd_sc_hd__decap_3
XFILLER_7_131 VGND VGND VPWR VPWR sky130_fd_sc_hd__fill_2
XFILLER_4_16 VGND VGND VPWR VPWR sky130_fd_sc_hd__fill_1
XFILLER_4_27 VGND VGND VPWR VPWR sky130_fd_sc_hd__fill_1
Xinput5 mem_dout[4] VGND VGND VPWR VPWR net5 sky130_fd_sc_hd__clkbuf_1
X_287_ net6 _145_ _134_ net41 VGND VGND VPWR VPWR _037_ sky130_fd_sc_hd__o211a_1
XFILLER_10_59 VPWR VGND VPWR VGND sky130_ef_sc_hd__decap_12
X_210_ net53 _079_ _082_ VGND VGND VPWR VPWR _012_ sky130_fd_sc_hd__a21o_1
XFILLER_21_47 VGND VGND VPWR VPWR sky130_fd_sc_hd__decap_8
XFILLER_7_49 VGND VGND VPWR VPWR sky130_fd_sc_hd__decap_6
XFILLER_21_106 VGND VGND VPWR VPWR sky130_fd_sc_hd__decap_6
XTAP_TAPCELL_ROW_1_50 VGND VPWR sky130_fd_sc_hd__tapvpwrvgnd_1
X_286_ net72 _144_ VGND VGND VPWR VPWR _134_ sky130_fd_sc_hd__or2_1
Xinput6 mem_dout[5] VGND VGND VPWR VPWR net6 sky130_fd_sc_hd__clkbuf_1
XFILLER_10_27 VGND VGND VPWR VPWR sky130_fd_sc_hd__fill_1
XPHY_EDGE_ROW_14_Right_14 VGND VGND VPWR VPWR sky130_fd_sc_hd__decap_3
X_338_ net36 VGND VGND VPWR VPWR net35 sky130_fd_sc_hd__clkbuf_1
X_269_ net46 state\[0\] VGND VGND VPWR VPWR _125_ sky130_fd_sc_hd__nor2_1
XTAP_TAPCELL_ROW_11_70 VGND VPWR sky130_fd_sc_hd__tapvpwrvgnd_1
XFILLER_11_81 VGND VGND VPWR VPWR sky130_fd_sc_hd__fill_2
XPHY_EDGE_ROW_4_Right_4 VGND VGND VPWR VPWR sky130_fd_sc_hd__decap_3
XFILLER_8_82 VGND VGND VPWR VPWR sky130_fd_sc_hd__fill_2
XFILLER_8_93 VGND VGND VPWR VPWR sky130_fd_sc_hd__decap_6
Xfanout39 _051_ VGND VGND VPWR VPWR net39 sky130_fd_sc_hd__buf_2
XFILLER_5_50 VGND VGND VPWR VPWR sky130_fd_sc_hd__decap_6
X_285_ net5 _145_ _133_ net41 VGND VGND VPWR VPWR _036_ sky130_fd_sc_hd__o211a_1
XTAP_TAPCELL_ROW_1_51 VGND VPWR sky130_fd_sc_hd__tapvpwrvgnd_1
Xinput7 mem_dout[6] VGND VGND VPWR VPWR net7 sky130_fd_sc_hd__clkbuf_1
XFILLER_19_26 VGND VGND VPWR VPWR sky130_fd_sc_hd__fill_2
X_337_ net36 VGND VGND VPWR VPWR net34 sky130_fd_sc_hd__clkbuf_1
X_199_ state\[6\] state\[5\] read_data\[7\] read_data\[6\] VGND VGND VPWR VPWR _074_
+ sky130_fd_sc_hd__o211a_1
X_268_ net57 _053_ _121_ net43 VGND VGND VPWR VPWR _028_ sky130_fd_sc_hd__o211a_1
XFILLER_21_16 VGND VGND VPWR VPWR sky130_fd_sc_hd__decap_4
XTAP_TAPCELL_ROW_11_71 VGND VPWR sky130_fd_sc_hd__tapvpwrvgnd_1
XFILLER_21_119 VPWR VGND VPWR VGND sky130_ef_sc_hd__decap_12
XFILLER_16_27 VGND VGND VPWR VPWR sky130_fd_sc_hd__fill_1
Xinput10 start VGND VGND VPWR VPWR net10 sky130_fd_sc_hd__buf_1
XFILLER_22_70 VGND VGND VPWR VPWR sky130_fd_sc_hd__decap_3
XTAP_TAPCELL_ROW_22_92 VGND VPWR sky130_fd_sc_hd__tapvpwrvgnd_1
XPHY_EDGE_ROW_14_Left_37 VGND VGND VPWR VPWR sky130_fd_sc_hd__decap_3
XFILLER_4_104 VGND VGND VPWR VPWR sky130_fd_sc_hd__fill_1
XPHY_EDGE_ROW_17_Left_40 VGND VGND VPWR VPWR sky130_fd_sc_hd__decap_3
X_284_ net66 _144_ VGND VGND VPWR VPWR _133_ sky130_fd_sc_hd__or2_1
Xinput8 mem_dout[7] VGND VGND VPWR VPWR net8 sky130_fd_sc_hd__clkbuf_1
XFILLER_14_93 VGND VGND VPWR VPWR sky130_fd_sc_hd__fill_1
XPHY_EDGE_ROW_2_Left_25 VGND VGND VPWR VPWR sky130_fd_sc_hd__decap_3
X_336_ net36 VGND VGND VPWR VPWR net33 sky130_fd_sc_hd__clkbuf_1
X_198_ read_data\[5\] read_data\[4\] read_data\[3\] read_data\[2\] VGND VGND VPWR
+ VPWR _073_ sky130_fd_sc_hd__and4_1
X_267_ net59 _123_ _124_ net42 VGND VGND VPWR VPWR _027_ sky130_fd_sc_hd__o211a_1
XTAP_TAPCELL_ROW_7_62 VGND VPWR sky130_fd_sc_hd__tapvpwrvgnd_1
X_319_ clknet_2_3__leaf_clk _027_ VGND VGND VPWR VPWR net37 sky130_fd_sc_hd__dfxtp_1
XTAP_TAPCELL_ROW_22_93 VGND VPWR sky130_fd_sc_hd__tapvpwrvgnd_1
XFILLER_12_109 VGND VGND VPWR VPWR sky130_fd_sc_hd__decap_3
XFILLER_22_93 VGND VGND VPWR VPWR sky130_fd_sc_hd__fill_1
XFILLER_7_113 VGND VGND VPWR VPWR sky130_fd_sc_hd__fill_2
XTAP_TAPCELL_ROW_17_82 VGND VPWR sky130_fd_sc_hd__tapvpwrvgnd_1
XFILLER_5_96 VGND VGND VPWR VPWR sky130_fd_sc_hd__fill_2
X_283_ net4 _145_ _132_ net41 VGND VGND VPWR VPWR _035_ sky130_fd_sc_hd__o211a_1
Xinput9 rst VGND VGND VPWR VPWR net9 sky130_fd_sc_hd__clkbuf_1
X_335_ net36 VGND VGND VPWR VPWR net32 sky130_fd_sc_hd__clkbuf_1
X_197_ _142_ _070_ _071_ VGND VGND VPWR VPWR _072_ sky130_fd_sc_hd__or3_1
X_266_ _048_ _122_ VGND VGND VPWR VPWR _124_ sky130_fd_sc_hd__nand2_1
XPHY_EDGE_ROW_10_Right_10 VGND VGND VPWR VPWR sky130_fd_sc_hd__decap_3
X_249_ net25 net24 _042_ net26 VGND VGND VPWR VPWR _110_ sky130_fd_sc_hd__a31o_1
X_318_ clknet_2_2__leaf_clk _026_ VGND VGND VPWR VPWR net36 sky130_fd_sc_hd__dfxtp_1
XTAP_TAPCELL_ROW_7_63 VGND VPWR sky130_fd_sc_hd__tapvpwrvgnd_1
XTAP_TAPCELL_ROW_22_94 VGND VPWR sky130_fd_sc_hd__tapvpwrvgnd_1
XFILLER_16_29 VGND VGND VPWR VPWR sky130_fd_sc_hd__fill_1
XFILLER_7_103 VGND VGND VPWR VPWR sky130_fd_sc_hd__fill_2
XFILLER_14_7 VGND VGND VPWR VPWR sky130_fd_sc_hd__fill_2
XTAP_TAPCELL_ROW_17_83 VGND VPWR sky130_fd_sc_hd__tapvpwrvgnd_1
XFILLER_17_72 VPWR VGND VPWR VGND sky130_ef_sc_hd__decap_12
XPHY_EDGE_ROW_8_Right_8 VGND VGND VPWR VPWR sky130_fd_sc_hd__decap_3
Xhold1 net11 VGND VGND VPWR VPWR net47 sky130_fd_sc_hd__dlygate4sd3_1
X_282_ net67 _144_ VGND VGND VPWR VPWR _132_ sky130_fd_sc_hd__or2_1
XFILLER_14_40 VGND VGND VPWR VPWR sky130_fd_sc_hd__decap_6
XFILLER_18_127 VGND VGND VPWR VPWR sky130_fd_sc_hd__decap_6
XFILLER_4_6 VGND VGND VPWR VPWR sky130_fd_sc_hd__fill_2
X_334_ net36 VGND VGND VPWR VPWR net31 sky130_fd_sc_hd__clkbuf_1
X_196_ read_data\[7\] read_data\[6\] read_data\[5\] read_data\[4\] VGND VGND VPWR
+ VPWR _071_ sky130_fd_sc_hd__or4_1
X_265_ phase\[2\] _119_ _120_ _053_ VGND VGND VPWR VPWR _123_ sky130_fd_sc_hd__o22a_1
X_179_ net25 net40 _059_ VGND VGND VPWR VPWR _060_ sky130_fd_sc_hd__or3_1
X_248_ net26 _060_ VGND VGND VPWR VPWR _109_ sky130_fd_sc_hd__xnor2_1
XFILLER_11_52 VGND VGND VPWR VPWR sky130_fd_sc_hd__decap_4
X_317_ clknet_2_3__leaf_clk _025_ VGND VGND VPWR VPWR net27 sky130_fd_sc_hd__dfxtp_2
XFILLER_14_130 VGND VGND VPWR VPWR sky130_fd_sc_hd__decap_3
XTAP_TAPCELL_ROW_22_95 VGND VPWR sky130_fd_sc_hd__tapvpwrvgnd_1
Xclkbuf_2_2__f_clk clknet_0_clk VGND VGND VPWR VPWR clknet_2_2__leaf_clk sky130_fd_sc_hd__clkbuf_16
XFILLER_17_84 VPWR VGND VPWR VGND sky130_ef_sc_hd__decap_12
Xhold2 net16 VGND VGND VPWR VPWR net48 sky130_fd_sc_hd__dlygate4sd3_1
X_281_ net3 _145_ _131_ net41 VGND VGND VPWR VPWR _034_ sky130_fd_sc_hd__o211a_1
XFILLER_14_63 VGND VGND VPWR VPWR sky130_fd_sc_hd__decap_4
XFILLER_14_85 VGND VGND VPWR VPWR sky130_fd_sc_hd__decap_8
X_333_ net36 VGND VGND VPWR VPWR net30 sky130_fd_sc_hd__clkbuf_1
X_195_ read_data\[3\] read_data\[2\] read_data\[1\] read_data\[0\] VGND VGND VPWR
+ VPWR _070_ sky130_fd_sc_hd__or4_1
X_264_ state\[3\] _141_ net39 _119_ _049_ VGND VGND VPWR VPWR _122_ sky130_fd_sc_hd__o311a_1
XPHY_EDGE_ROW_6_Left_29 VGND VGND VPWR VPWR sky130_fd_sc_hd__decap_3
X_247_ net25 _090_ _091_ _108_ net42 VGND VGND VPWR VPWR _023_ sky130_fd_sc_hd__o221a_1
X_316_ clknet_2_3__leaf_clk _024_ VGND VGND VPWR VPWR net26 sky130_fd_sc_hd__dfxtp_1
XFILLER_11_20 VGND VGND VPWR VPWR sky130_fd_sc_hd__decap_4
XFILLER_20_101 VGND VGND VPWR VPWR sky130_fd_sc_hd__fill_1
X_178_ net23 net22 net21 net20 VGND VGND VPWR VPWR _059_ sky130_fd_sc_hd__or4_2
XFILLER_22_85 VGND VGND VPWR VPWR sky130_fd_sc_hd__decap_8
XFILLER_17_96 VGND VGND VPWR VPWR sky130_fd_sc_hd__decap_4
XPHY_EDGE_ROW_9_Left_32 VGND VGND VPWR VPWR sky130_fd_sc_hd__decap_3
Xhold3 net18 VGND VGND VPWR VPWR net49 sky130_fd_sc_hd__dlygate4sd3_1
X_280_ net71 _144_ VGND VGND VPWR VPWR _131_ sky130_fd_sc_hd__or2_1
XPHY_EDGE_ROW_22_Left_45 VGND VGND VPWR VPWR sky130_fd_sc_hd__decap_3
X_332_ net36 VGND VGND VPWR VPWR net29 sky130_fd_sc_hd__clkbuf_1
X_194_ net60 _047_ _067_ _069_ VGND VGND VPWR VPWR _000_ sky130_fd_sc_hd__a211o_1
X_263_ state\[3\] _049_ VGND VGND VPWR VPWR _121_ sky130_fd_sc_hd__nand2_1
X_315_ clknet_2_3__leaf_clk _023_ VGND VGND VPWR VPWR net25 sky130_fd_sc_hd__dfxtp_2
X_177_ net21 net20 VGND VGND VPWR VPWR _058_ sky130_fd_sc_hd__or2_1
X_246_ _044_ net39 _107_ _106_ _141_ VGND VGND VPWR VPWR _108_ sky130_fd_sc_hd__a32o_1
XFILLER_22_42 VPWR VGND VPWR VGND sky130_ef_sc_hd__decap_12
XFILLER_11_113 VGND VGND VPWR VPWR sky130_fd_sc_hd__fill_1
X_229_ net22 _058_ VGND VGND VPWR VPWR _094_ sky130_fd_sc_hd__xnor2_1
XFILLER_8_99 VGND VGND VPWR VPWR sky130_fd_sc_hd__fill_1
Xhold4 net14 VGND VGND VPWR VPWR net50 sky130_fd_sc_hd__dlygate4sd3_1
XFILLER_17_53 VGND VGND VPWR VPWR sky130_fd_sc_hd__decap_3
XTAP_TAPCELL_ROW_4_56 VGND VPWR sky130_fd_sc_hd__tapvpwrvgnd_1
XFILLER_12_7 VGND VGND VPWR VPWR sky130_fd_sc_hd__fill_2
XPHY_EDGE_ROW_17_Right_17 VGND VGND VPWR VPWR sky130_fd_sc_hd__decap_3
XTAP_TAPCELL_ROW_14_76 VGND VPWR sky130_fd_sc_hd__tapvpwrvgnd_1
X_331_ clknet_2_0__leaf_clk _039_ VGND VGND VPWR VPWR read_data\[7\] sky130_fd_sc_hd__dfxtp_1
X_262_ state\[3\] _049_ VGND VGND VPWR VPWR _120_ sky130_fd_sc_hd__and2_1
X_193_ state\[0\] net10 _068_ net46 VGND VGND VPWR VPWR _069_ sky130_fd_sc_hd__a211o_1
XFILLER_17_130 VGND VGND VPWR VPWR sky130_fd_sc_hd__decap_3
XFILLER_2_24 VGND VGND VPWR VPWR sky130_fd_sc_hd__decap_4
XFILLER_2_6 VGND VGND VPWR VPWR sky130_fd_sc_hd__fill_2
X_314_ clknet_2_3__leaf_clk _022_ VGND VGND VPWR VPWR net24 sky130_fd_sc_hd__dfxtp_1
X_245_ net40 _042_ net25 VGND VGND VPWR VPWR _107_ sky130_fd_sc_hd__a21o_1
X_176_ net41 net60 _047_ _057_ net64 VGND VGND VPWR VPWR _005_ sky130_fd_sc_hd__a32o_1
XFILLER_14_122 VGND VGND VPWR VPWR sky130_fd_sc_hd__decap_8
XFILLER_22_98 VPWR VGND VPWR VGND sky130_ef_sc_hd__decap_12
XFILLER_22_65 VGND VGND VPWR VPWR sky130_fd_sc_hd__fill_1
XFILLER_22_54 VGND VGND VPWR VPWR sky130_fd_sc_hd__fill_2
XFILLER_0_3 VPWR VGND VPWR VGND sky130_ef_sc_hd__decap_12
X_159_ net25 net40 _042_ VGND VGND VPWR VPWR _044_ sky130_fd_sc_hd__nand3_1
X_228_ net21 _090_ _091_ _093_ net44 VGND VGND VPWR VPWR _019_ sky130_fd_sc_hd__o221a_1
XFILLER_17_65 VGND VGND VPWR VPWR sky130_fd_sc_hd__decap_3
XFILLER_3_121 VGND VGND VPWR VPWR sky130_fd_sc_hd__fill_1
XTAP_TAPCELL_ROW_4_57 VGND VPWR sky130_fd_sc_hd__tapvpwrvgnd_1
Xhold5 net12 VGND VGND VPWR VPWR net51 sky130_fd_sc_hd__dlygate4sd3_1
XFILLER_0_113 VGND VGND VPWR VPWR sky130_fd_sc_hd__decap_8
XFILLER_5_57 VGND VGND VPWR VPWR sky130_fd_sc_hd__fill_2
XTAP_TAPCELL_ROW_14_77 VGND VPWR sky130_fd_sc_hd__tapvpwrvgnd_1
XFILLER_14_33 VGND VGND VPWR VPWR sky130_fd_sc_hd__fill_1
X_330_ clknet_2_0__leaf_clk _038_ VGND VGND VPWR VPWR read_data\[6\] sky130_fd_sc_hd__dfxtp_1
X_261_ phase\[1\] phase\[0\] _050_ VGND VGND VPWR VPWR _119_ sky130_fd_sc_hd__or3_1
X_192_ phase\[1\] _143_ VGND VGND VPWR VPWR _068_ sky130_fd_sc_hd__and2_1
X_313_ clknet_2_3__leaf_clk _021_ VGND VGND VPWR VPWR net23 sky130_fd_sc_hd__dfxtp_1
X_244_ _060_ _105_ VGND VGND VPWR VPWR _106_ sky130_fd_sc_hd__nand2_1
X_175_ phase\[1\] _047_ net45 VGND VGND VPWR VPWR _057_ sky130_fd_sc_hd__a21oi_1
XFILLER_22_77 VGND VGND VPWR VPWR sky130_fd_sc_hd__decap_3
X_158_ net40 _042_ VGND VGND VPWR VPWR _043_ sky130_fd_sc_hd__nand2_1
X_227_ _141_ net39 _092_ VGND VGND VPWR VPWR _093_ sky130_fd_sc_hd__mux2_1
Xhold6 net17 VGND VGND VPWR VPWR net52 sky130_fd_sc_hd__dlygate4sd3_1
XFILLER_3_111 VGND VGND VPWR VPWR sky130_fd_sc_hd__fill_1
XPHY_EDGE_ROW_3_Right_3 VGND VGND VPWR VPWR sky130_fd_sc_hd__decap_3
XFILLER_14_23 VGND VGND VPWR VPWR sky130_fd_sc_hd__decap_4
X_260_ net36 _117_ _118_ net42 VGND VGND VPWR VPWR _026_ sky130_fd_sc_hd__o211a_1
X_191_ state\[4\] _063_ _066_ phase\[0\] VGND VGND VPWR VPWR _067_ sky130_fd_sc_hd__o31a_1
XFILLER_11_57 VGND VGND VPWR VPWR sky130_fd_sc_hd__decap_4
X_312_ clknet_2_3__leaf_clk _020_ VGND VGND VPWR VPWR net22 sky130_fd_sc_hd__dfxtp_2
X_243_ net40 _059_ net25 VGND VGND VPWR VPWR _105_ sky130_fd_sc_hd__o21ai_1
X_174_ net42 _049_ VGND VGND VPWR VPWR _003_ sky130_fd_sc_hd__nand2_1
XFILLER_20_127 VGND VGND VPWR VPWR sky130_fd_sc_hd__decap_6
XFILLER_22_23 VGND VGND VPWR VPWR sky130_fd_sc_hd__fill_1
X_157_ net23 net22 net21 net20 VGND VGND VPWR VPWR _042_ sky130_fd_sc_hd__and4_2
XFILLER_19_3 VGND VGND VPWR VPWR sky130_fd_sc_hd__fill_1
X_226_ _040_ _058_ VGND VGND VPWR VPWR _092_ sky130_fd_sc_hd__and2_1
XFILLER_8_25 VGND VGND VPWR VPWR sky130_fd_sc_hd__decap_3
XFILLER_17_45 VGND VGND VPWR VPWR sky130_fd_sc_hd__decap_8
Xhold7 net13 VGND VGND VPWR VPWR net53 sky130_fd_sc_hd__dlygate4sd3_1
X_209_ net22 _078_ net45 VGND VGND VPWR VPWR _082_ sky130_fd_sc_hd__a21o_1
XFILLER_0_81 VGND VGND VPWR VPWR sky130_fd_sc_hd__decap_3
XPHY_EDGE_ROW_13_Left_36 VGND VGND VPWR VPWR sky130_fd_sc_hd__decap_3
XPHY_EDGE_ROW_22_Right_22 VGND VGND VPWR VPWR sky130_fd_sc_hd__decap_3
XPHY_EDGE_ROW_13_Right_13 VGND VGND VPWR VPWR sky130_fd_sc_hd__decap_3
X_190_ state\[0\] _143_ VGND VGND VPWR VPWR _066_ sky130_fd_sc_hd__nor2_1
X_311_ clknet_2_1__leaf_clk _019_ VGND VGND VPWR VPWR net21 sky130_fd_sc_hd__dfxtp_1
X_242_ net40 _090_ _091_ _104_ net43 VGND VGND VPWR VPWR _022_ sky130_fd_sc_hd__o221a_1
X_173_ net42 phase\[2\] _054_ _056_ VGND VGND VPWR VPWR _002_ sky130_fd_sc_hd__a31o_1
XPHY_EDGE_ROW_1_Left_24 VGND VGND VPWR VPWR sky130_fd_sc_hd__decap_3
XFILLER_22_57 VGND VGND VPWR VPWR sky130_fd_sc_hd__decap_8
XFILLER_22_35 VGND VGND VPWR VPWR sky130_fd_sc_hd__decap_3
X_156_ net22 net21 net20 VGND VGND VPWR VPWR _041_ sky130_fd_sc_hd__and3_1
X_225_ net20 _090_ _091_ _088_ net41 VGND VGND VPWR VPWR _018_ sky130_fd_sc_hd__o221a_1
Xhold8 net15 VGND VGND VPWR VPWR net54 sky130_fd_sc_hd__dlygate4sd3_1
XFILLER_17_57 VGND VGND VPWR VPWR sky130_fd_sc_hd__decap_8
X_208_ net51 _079_ _081_ VGND VGND VPWR VPWR _011_ sky130_fd_sc_hd__a21o_1
XFILLER_5_38 VGND VGND VPWR VPWR sky130_fd_sc_hd__decap_3
Xclkbuf_2_3__f_clk clknet_0_clk VGND VGND VPWR VPWR clknet_2_3__leaf_clk sky130_fd_sc_hd__clkbuf_16
XFILLER_15_90 VGND VGND VPWR VPWR sky130_fd_sc_hd__decap_8
X_310_ clknet_2_1__leaf_clk _018_ VGND VGND VPWR VPWR net20 sky130_fd_sc_hd__dfxtp_2
X_241_ _043_ net39 _103_ _102_ _141_ VGND VGND VPWR VPWR _104_ sky130_fd_sc_hd__a32o_1
X_172_ net42 phase\[0\] _143_ VGND VGND VPWR VPWR _056_ sky130_fd_sc_hd__and3_1
X_155_ net21 net20 VGND VGND VPWR VPWR _040_ sky130_fd_sc_hd__nand2_1
X_224_ state\[6\] _047_ _090_ VGND VGND VPWR VPWR _091_ sky130_fd_sc_hd__a21bo_2
Xhold9 net19 VGND VGND VPWR VPWR net55 sky130_fd_sc_hd__dlygate4sd3_1
X_207_ net21 _078_ net45 VGND VGND VPWR VPWR _081_ sky130_fd_sc_hd__a21o_1
XPHY_EDGE_ROW_7_Right_7 VGND VGND VPWR VPWR sky130_fd_sc_hd__decap_3
XFILLER_6_71 VGND VGND VPWR VPWR sky130_fd_sc_hd__fill_2
XFILLER_2_29 VGND VGND VPWR VPWR sky130_fd_sc_hd__fill_2
X_240_ net40 _042_ VGND VGND VPWR VPWR _103_ sky130_fd_sc_hd__or2_1
X_171_ net42 _144_ _054_ _055_ VGND VGND VPWR VPWR _001_ sky130_fd_sc_hd__a22o_1
XFILLER_22_15 VGND VGND VPWR VPWR sky130_fd_sc_hd__decap_8
XFILLER_8_17 VGND VGND VPWR VPWR sky130_fd_sc_hd__decap_8
X_223_ net27 _139_ _061_ _089_ _053_ VGND VGND VPWR VPWR _090_ sky130_fd_sc_hd__o311a_2
X_154_ phase\[2\] _143_ VGND VGND VPWR VPWR _145_ sky130_fd_sc_hd__nand2_2
X_206_ net47 _079_ _080_ VGND VGND VPWR VPWR _010_ sky130_fd_sc_hd__a21o_1
XFILLER_17_3 VGND VGND VPWR VPWR sky130_fd_sc_hd__decap_3
XFILLER_9_71 VGND VGND VPWR VPWR sky130_fd_sc_hd__fill_2
XFILLER_14_27 VGND VGND VPWR VPWR sky130_fd_sc_hd__fill_1
X_170_ net42 phase\[1\] VGND VGND VPWR VPWR _055_ sky130_fd_sc_hd__and2_1
X_299_ clknet_2_1__leaf_clk _014_ VGND VGND VPWR VPWR net15 sky130_fd_sc_hd__dfxtp_1
XFILLER_3_62 VGND VGND VPWR VPWR sky130_fd_sc_hd__fill_1
XFILLER_9_132 VGND VGND VPWR VPWR sky130_fd_sc_hd__fill_1
XPHY_EDGE_ROW_5_Left_28 VGND VGND VPWR VPWR sky130_fd_sc_hd__decap_3
X_153_ phase\[2\] _143_ VGND VGND VPWR VPWR _144_ sky130_fd_sc_hd__and2_1
XFILLER_6_124 VGND VGND VPWR VPWR sky130_fd_sc_hd__fill_1
X_222_ phase\[1\] _143_ VGND VGND VPWR VPWR _089_ sky130_fd_sc_hd__nand2b_1
XFILLER_10_131 VGND VGND VPWR VPWR sky130_fd_sc_hd__fill_2
XFILLER_3_105 VGND VGND VPWR VPWR sky130_fd_sc_hd__decap_6
X_205_ net20 _078_ net45 VGND VGND VPWR VPWR _080_ sky130_fd_sc_hd__a21o_1
XFILLER_0_85 VPWR VGND VPWR VGND sky130_ef_sc_hd__decap_12
XFILLER_0_41 VGND VGND VPWR VPWR sky130_fd_sc_hd__decap_4
XPHY_EDGE_ROW_8_Left_31 VGND VGND VPWR VPWR sky130_fd_sc_hd__decap_3
XFILLER_20_60 VGND VGND VPWR VPWR sky130_fd_sc_hd__fill_2
XFILLER_9_6 VPWR VGND VPWR VGND sky130_ef_sc_hd__decap_12
XTAP_TAPCELL_ROW_2_52 VGND VPWR sky130_fd_sc_hd__tapvpwrvgnd_1
XPHY_EDGE_ROW_21_Left_44 VGND VGND VPWR VPWR sky130_fd_sc_hd__decap_3
X_298_ clknet_2_1__leaf_clk _013_ VGND VGND VPWR VPWR net14 sky130_fd_sc_hd__dfxtp_1
XTAP_TAPCELL_ROW_12_72 VGND VPWR sky130_fd_sc_hd__tapvpwrvgnd_1
X_221_ _141_ net39 net20 VGND VGND VPWR VPWR _088_ sky130_fd_sc_hd__o21ba_1
X_152_ state\[6\] state\[5\] state\[2\] state\[1\] VGND VGND VPWR VPWR _143_ sky130_fd_sc_hd__or4_2
XFILLER_17_28 VGND VGND VPWR VPWR sky130_fd_sc_hd__fill_2
XFILLER_3_128 VGND VGND VPWR VPWR sky130_fd_sc_hd__fill_1
X_204_ diag_captured _077_ VGND VGND VPWR VPWR _079_ sky130_fd_sc_hd__or2_2
XFILLER_0_97 VPWR VGND VPWR VGND sky130_ef_sc_hd__decap_12
XFILLER_0_109 VGND VGND VPWR VPWR sky130_fd_sc_hd__decap_3
XFILLER_22_3 VPWR VGND VPWR VGND sky130_ef_sc_hd__decap_12
XFILLER_14_29 VGND VGND VPWR VPWR sky130_fd_sc_hd__decap_4
XFILLER_6_85 VGND VGND VPWR VPWR sky130_fd_sc_hd__decap_4
XTAP_TAPCELL_ROW_2_53 VGND VPWR sky130_fd_sc_hd__tapvpwrvgnd_1
X_297_ clknet_2_1__leaf_clk _012_ VGND VGND VPWR VPWR net13 sky130_fd_sc_hd__dfxtp_1
X_151_ state\[2\] state\[1\] VGND VGND VPWR VPWR _142_ sky130_fd_sc_hd__nor2_1
X_220_ net49 _079_ _087_ VGND VGND VPWR VPWR _017_ sky130_fd_sc_hd__a21o_1
XTAP_TAPCELL_ROW_12_73 VGND VPWR sky130_fd_sc_hd__tapvpwrvgnd_1
XFILLER_0_21 VGND VGND VPWR VPWR sky130_fd_sc_hd__decap_3
X_203_ _137_ _068_ _072_ _076_ VGND VGND VPWR VPWR _078_ sky130_fd_sc_hd__and4_2
XFILLER_9_63 VGND VGND VPWR VPWR sky130_fd_sc_hd__decap_8
XFILLER_18_83 VGND VGND VPWR VPWR sky130_fd_sc_hd__fill_1
X_296_ clknet_2_1__leaf_clk _011_ VGND VGND VPWR VPWR net12 sky130_fd_sc_hd__dfxtp_1
XFILLER_3_87 VGND VGND VPWR VPWR sky130_fd_sc_hd__decap_3
XFILLER_3_32 VGND VGND VPWR VPWR sky130_fd_sc_hd__decap_3
X_150_ state\[5\] state\[1\] VGND VGND VPWR VPWR _141_ sky130_fd_sc_hd__or2_4
XFILLER_12_63 VGND VGND VPWR VPWR sky130_fd_sc_hd__fill_1
XPHY_EDGE_ROW_16_Right_16 VGND VGND VPWR VPWR sky130_fd_sc_hd__decap_3
X_279_ net2 _145_ _130_ net41 VGND VGND VPWR VPWR _033_ sky130_fd_sc_hd__o211a_1
XTAP_TAPCELL_ROW_8_64 VGND VPWR sky130_fd_sc_hd__tapvpwrvgnd_1
X_202_ _068_ _072_ _076_ VGND VGND VPWR VPWR _077_ sky130_fd_sc_hd__nand3_1
XFILLER_0_55 VGND VGND VPWR VPWR sky130_fd_sc_hd__fill_1
XFILLER_9_53 VGND VGND VPWR VPWR sky130_fd_sc_hd__decap_3
XTAP_TAPCELL_ROW_18_84 VGND VPWR sky130_fd_sc_hd__tapvpwrvgnd_1
XPHY_EDGE_ROW_2_Right_2 VGND VGND VPWR VPWR sky130_fd_sc_hd__decap_3
XFILLER_6_54 VGND VGND VPWR VPWR sky130_fd_sc_hd__fill_1
XFILLER_17_118 VPWR VGND VPWR VGND sky130_ef_sc_hd__decap_12
XFILLER_22_132 VGND VGND VPWR VPWR sky130_fd_sc_hd__fill_1
XFILLER_22_110 VGND VGND VPWR VPWR sky130_fd_sc_hd__fill_2
XFILLER_9_103 VGND VGND VPWR VPWR sky130_fd_sc_hd__fill_2
X_295_ clknet_2_1__leaf_clk _010_ VGND VGND VPWR VPWR net11 sky130_fd_sc_hd__dfxtp_1
X_278_ net68 _144_ VGND VGND VPWR VPWR _130_ sky130_fd_sc_hd__or2_1
XFILLER_5_3 VGND VGND VPWR VPWR sky130_fd_sc_hd__decap_8
XTAP_TAPCELL_ROW_8_65 VGND VPWR sky130_fd_sc_hd__tapvpwrvgnd_1
X_201_ _073_ _074_ _075_ VGND VGND VPWR VPWR _076_ sky130_fd_sc_hd__nand3_1
XTAP_TAPCELL_ROW_18_85 VGND VPWR sky130_fd_sc_hd__tapvpwrvgnd_1
XFILLER_18_85 VPWR VGND VPWR VGND sky130_ef_sc_hd__decap_12
XPHY_EDGE_ROW_12_Left_35 VGND VGND VPWR VPWR sky130_fd_sc_hd__decap_3
XFILLER_20_3 VGND VGND VPWR VPWR sky130_fd_sc_hd__fill_1
Xoutput30 net30 VGND VGND VPWR VPWR mem_din[1] sky130_fd_sc_hd__buf_2
.ends
